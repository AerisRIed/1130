#
# Template for RALF file used by RAL environment
#

# ToDo: cdn_phy.ralf file needs to be modified according to user configuration 
# to generate ral_cdn_phy block inside ral_cdn_phy.sv file
# Default implementation of register, memory, field and block 
# kept inside this cdn_phy.ralf file

block cdn_phy {
   bytes 4;
   register CHIP_ID @'h0000 {
      field REVISION_ID {
         bits 8;
         access ro;
         reset 'h03;
      }
      field CHIP_ID {
         bits 8;
         access ro;
         reset 'h5A;
      }
      field PRODUCT_ID {
         bits 10;
         access ro;
         reset 'h176;
      }
   }
  
   memory cdn_phy_RAM @'h0800 {
      size 1k;
      bits 32;
      access rw;
   }
}
